.SUBCKT 4input0xACCC_X1 A B C D VDD VSS Y
* Canonical: 0b0000000111101111
* Function: Y = binate [recursive NAND/NOR, 16 TR]
* Transistors: 16
MP3 bg B VDD VDD pmos_rvt W=46.0n L=16n nfin=2
MP4 bg C bgpb VDD pmos_rvt W=46.0n L=16n nfin=2
MP5 bgpb D VDD VDD pmos_rvt W=46.0n L=16n nfin=2
MbcP1 npbc0 A VDD VDD pmos_rvt W=46.0n L=16n nfin=2
MbcP3 npbc2 D VDD VDD pmos_rvt W=46.0n L=16n nfin=2
MbcP4 npbc0 C npbc2 VDD pmos_rvt W=46.0n L=16n nfin=2
MbcP5 Y B npbc0 VDD pmos_rvt W=46.0n L=16n nfin=2
MbcP6 Y bg npbc0 VDD pmos_rvt W=46.0n L=16n nfin=2
MN0 bg B bgna VSS nmos_rvt W=46.0n L=16n nfin=2
MN1 bgna C VSS VSS nmos_rvt W=46.0n L=16n nfin=2
MN2 bgna D VSS VSS nmos_rvt W=46.0n L=16n nfin=2
MbcN1 Y A nsbc0 VSS nmos_rvt W=46.0n L=16n nfin=2
MbcN2 nsbc0 D VSS VSS nmos_rvt W=46.0n L=16n nfin=2
MbcN3 nsbc0 C VSS VSS nmos_rvt W=46.0n L=16n nfin=2
MbcN5 Y B nsbc4 VSS nmos_rvt W=46.0n L=16n nfin=2
MbcN6 nsbc4 bg VSS VSS nmos_rvt W=46.0n L=16n nfin=2
.ENDS
