.SUBCKT 3input0x2D_X1_DH_N A1 A2 A3 VDD VSS Y
MM0 n1 A2 planar VSS nmos_rvt w=46.0n l=16n nfin=2
MM1 n1 A3 VSS VSS nmos_rvt w=46.0n l=16n nfin=2
MM2 n2 A1 VSS VSS nmos_rvt w=46.0n l=16n nfin=2
MM3 n2 A2 planar VSS nmos_rvt w=46.0n l=16n nfin=2
MM4 n2 A3 planar VSS nmos_rvt w=46.0n l=16n nfin=2
MM5 n3 A3 planar VDD pmos_rvt w=46.0n l=16n nfin=2
MM6 n3 A2 planar VDD pmos_rvt w=46.0n l=16n nfin=2
MM7 VDD A1 n3 VDD pmos_rvt w=46.0n l=16n nfin=2
MM8 n4 A3 VDD VDD pmos_rvt w=46.0n l=16n nfin=2
MM9 planar A2 n4 VDD pmos_rvt w=46.0n l=16n nfin=2
MM10 n5 planar VDD VDD pmos_rvt w=46.0n l=16n nfin=2
MM11 n5 A3 Y VDD pmos_rvt w=46.0n l=16n nfin=2
MM12 n5 A1 n6 VDD pmos_rvt w=46.0n l=16n nfin=2
MM13 n6 planar Y VDD pmos_rvt w=46.0n l=16n nfin=2
MM14 n6 A2 VDD VDD pmos_rvt w=46.0n l=16n nfin=2
MM15 n7 planar VSS VSS nmos_rvt w=46.0n l=16n nfin=2
MM16 Y A2 n7 VSS nmos_rvt w=46.0n l=16n nfin=2
MM17 n8 A1 n7 VSS nmos_rvt w=46.0n l=16n nfin=2
MM18 VSS A3 n8 VSS nmos_rvt w=46.0n l=16n nfin=2
MM19 Y planar n8 VSS nmos_rvt w=46.0n l=16n nfin=2
.ENDS
