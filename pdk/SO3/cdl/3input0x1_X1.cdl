.SUBCKT 3input0x1_X1 A1 A2 A3 VDD VSS Y
MM3 n1 A2 VSS VSS nmos_rvt w=46.0n l=16n nfin=2
MM2 nand2 A3 n1 VSS nmos_rvt w=46.0n l=16n nfin=2
MM1 nand2 A2 VDD VDD pmos_rvt w=46.0n l=16n nfin=2
MM0 nand2 A3 VDD VDD pmos_rvt w=46.0n l=16n nfin=2
MM7 VSS nand2 Y VSS nmos_rvt w=46.0n l=16n nfin=2
MM6 VSS A1 Y VSS nmos_rvt w=46.0n l=16n nfin=2
MM5 n2 A1 Y VDD pmos_rvt w=46.0n l=16n nfin=2
MM4 VDD nand2 n2 VDD pmos_rvt w=46.0n l=16n nfin=2
.ENDS
