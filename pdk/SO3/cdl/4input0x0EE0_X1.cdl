.SUBCKT 4input0x0EE0_X1 A B C D VDD VSS Y
* Canonical: 0b0000011001100110
* Function: Y = binate [recursive NAND/NOR, 14 TR]
* Transistors: 14
MP0 bgp0 C VDD VDD pmos_rvt W=46.0n L=16n nfin=2
MP1 bg D bgp0 VDD pmos_rvt W=46.0n L=16n nfin=2
MbcP2 npbc0 bg VDD VDD pmos_rvt W=46.0n L=16n nfin=2
MbcP3 npbc1 C npbc0 VDD pmos_rvt W=46.0n L=16n nfin=2
MbcP4 npbc1 D npbc0 VDD pmos_rvt W=46.0n L=16n nfin=2
MbcP5 Y A npbc1 VDD pmos_rvt W=46.0n L=16n nfin=2
MbcP6 Y B npbc1 VDD pmos_rvt W=46.0n L=16n nfin=2
MN2 bg C VSS VSS nmos_rvt W=46.0n L=16n nfin=2
MN3 bg D VSS VSS nmos_rvt W=46.0n L=16n nfin=2
MbcN0 Y bg VSS VSS nmos_rvt W=46.0n L=16n nfin=2
MbcN2 Y C nsbc1 VSS nmos_rvt W=46.0n L=16n nfin=2
MbcN3 nsbc1 D VSS VSS nmos_rvt W=46.0n L=16n nfin=2
MbcN5 Y A nsbc4 VSS nmos_rvt W=46.0n L=16n nfin=2
MbcN6 nsbc4 B VSS VSS nmos_rvt W=46.0n L=16n nfin=2
.ENDS
