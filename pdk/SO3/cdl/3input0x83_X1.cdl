.SUBCKT 3input0x83_X1 A1 A2 A3 VDD VSS Y
MM3 n1 A2 VSS VSS nmos_rvt w=46.0n l=16n nfin=2
MM2 nand2 A1 n1 VSS nmos_rvt w=46.0n l=16n nfin=2
MM1 nand2 A2 VDD VDD pmos_rvt w=46.0n l=16n nfin=2
MM0 nand2 A1 VDD VDD pmos_rvt w=46.0n l=16n nfin=2
MM4 n2 A1 VDD VDD pmos_rvt w=46.0n l=16n nfin=2
MM5 n2 A2 n3 VDD pmos_rvt w=46.0n l=16n nfin=2
MM6 Y nand2 VDD VDD pmos_rvt w=46.0n l=16n nfin=2
MM7 Y A3 n3 VDD pmos_rvt w=46.0n l=16n nfin=2
MM8 n4 nand2 Y VSS nmos_rvt w=46.0n l=16n nfin=2
MM9 n4 A1 VSS VSS nmos_rvt w=46.0n l=16n nfin=2
MM10 n4 A2 VSS VSS nmos_rvt w=46.0n l=16n nfin=2
MM11 VSS A3 n4 VSS nmos_rvt w=46.0n l=16n nfin=2
.ENDS
