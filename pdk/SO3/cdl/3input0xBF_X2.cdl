.SUBCKT 3input0xBF_X2 A1 A2 A3 VDD VSS Y
MM3 n1 A2 VDD VDD pmos_rvt w=46.0n l=16n nfin=2
MM2 nor2 A1 n1 VDD pmos_rvt w=46.0n l=16n nfin=2
MM1 nor2 A2 VSS VSS nmos_rvt w=46.0n l=16n nfin=2
MM0 nor2 A1 VSS VSS nmos_rvt w=46.0n l=16n nfin=2
MM4 Y A3 VDD VDD pmos_rvt w=92.0n l=16n nfin=4
MM5 Y nor2 VDD VDD pmos_rvt w=92.0n l=16n nfin=4
MM6 n4 nor2 VSS VSS nmos_rvt w=92.0n l=16n nfin=4
MM7 n4 A3 Y VSS nmos_rvt w=92.0n l=16n nfin=4
.ENDS
