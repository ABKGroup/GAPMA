.SUBCKT 3input0xB_X1 A1 A2 A3 VDD VSS Y
MM3 n1 A2 VSS VSS nmos_rvt w=46.0n l=16n nfin=2
MM2 nand2 A3 n1 VSS nmos_rvt w=46.0n l=16n nfin=2
MM1 nand2 A2 VDD VDD pmos_rvt w=46.0n l=16n nfin=2
MM0 nand2 A3 VDD VDD pmos_rvt w=46.0n l=16n nfin=2
MM5 na1 A1 VSS VSS nmos_rvt w=46.0n l=16n nfin=2
MM4 na1 A1 VDD VDD pmos_rvt w=46.0n l=16n nfin=2
MM9 VDD nand2 Y VDD pmos_rvt w=46.00n l=16n nfin=2
MM8 Y A2 n3 VDD pmos_rvt w=46.00n l=16n nfin=2
MM7 n3 A3 n2 VDD pmos_rvt w=46.00n l=16n nfin=2
MM6 VDD na1 n2 VDD pmos_rvt w=46.00n l=16n nfin=2
MM13 Y nand2 n4 VSS nmos_rvt w=46.00n l=16n nfin=2
MM12 VSS A3 n4 VSS nmos_rvt w=46.00n l=16n nfin=2
MM11 VSS A2 n4 VSS nmos_rvt w=46.00n l=16n nfin=2
MM10 VSS na1 n4 VSS nmos_rvt w=46.00n l=16n nfin=2
.ENDS
