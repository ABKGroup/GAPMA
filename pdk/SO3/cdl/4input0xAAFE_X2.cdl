.SUBCKT 4input0xAAFE_X2 A B C D VDD VSS Y
* Canonical: 0b1010101011111110
* Function: Y = binate [small-gate search, 12 TR]
* Transistors: 12
MP0 sg4 B VDD VDD pmos_rvt W=92.0n L=16n nfin=4
MP1 sg4 C VDD VDD pmos_rvt W=92.0n L=16n nfin=4
MP4 sg6 A VDD VDD pmos_rvt W=92.0n L=16n nfin=4
MP5 sg6 sg4 VDD VDD pmos_rvt W=92.0n L=16n nfin=4
MP8 Y D VDD VDD pmos_rvt W=92.0n L=16n nfin=4
MP9 Y sg6 VDD VDD pmos_rvt W=92.0n L=16n nfin=4
MN2 sg4 B sg4_ns0 VSS nmos_rvt W=92.0n L=16n nfin=4
MN3 sg4_ns0 C VSS VSS nmos_rvt W=92.0n L=16n nfin=4
MN6 sg6 A sg6_ns0 VSS nmos_rvt W=92.0n L=16n nfin=4
MN7 sg6_ns0 sg4 VSS VSS nmos_rvt W=92.0n L=16n nfin=4
MN10 Y D sg8_ns0 VSS nmos_rvt W=92.0n L=16n nfin=4
MN11 sg8_ns0 sg6 VSS VSS nmos_rvt W=92.0n L=16n nfin=4
.ENDS
