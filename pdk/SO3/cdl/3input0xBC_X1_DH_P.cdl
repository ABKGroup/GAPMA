.SUBCKT 3input0xBC_X1_DH_P A1 A2 A3 VDD VSS Y
MM3 VSS A1 nor2 VSS nmos_rvt w=46.0n l=16n nfin=2
MM2 VSS A2 nor2 VSS nmos_rvt w=46.0n l=16n nfin=2
MM1 n1 A2 nor2 VDD pmos_rvt w=46.0n l=16n nfin=2
MM0 VDD A1 n1 VDD pmos_rvt w=46.0n l=16n nfin=2
MM4 VDD A3 n2 VDD pmos_rvt w=46.0n l=16n nfin=2
MM5 VDD nor2 n2 VDD pmos_rvt w=46.0n l=16n nfin=2
MM6 Y A2 n2 VDD pmos_rvt w=46.0n l=16n nfin=2
MM7 Y A1 n2 VDD pmos_rvt w=46.0n l=16n nfin=2
MM8 VSS A2 n3 VSS nmos_rvt w=46.0n l=16n nfin=2
MM9 Y A1 n3 VSS nmos_rvt w=46.0n l=16n nfin=2
MM10 VSS nor2 n4 VSS nmos_rvt w=46.0n l=16n nfin=2
MM11 Y A3 n4 VSS nmos_rvt w=46.0n l=16n nfin=2
.ENDS
