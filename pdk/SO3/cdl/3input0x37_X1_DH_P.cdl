.SUBCKT 3input0x37_X1_DH_P A1 A2 A3 VDD VSS Y
MM0 na1 A1 VSS VSS nmos_rvt w=46.0n l=16n nfin=2
MM1 na1 A1 VDD VDD pmos_rvt w=46.0n l=16n nfin=2
MM2 n1 A1 VDD VDD pmos_rvt w=46.0n l=16n nfin=2
MM3 Y A3 n1 VDD pmos_rvt w=46.0n l=16n nfin=2
MM4 n2 na1 Y VDD pmos_rvt w=46.0n l=16n nfin=2
MM5 VDD A2 n2 VDD pmos_rvt w=46.0n l=16n nfin=2
MM6 n3 A3 VSS VSS nmos_rvt w=46.0n l=16n nfin=2
MM7 n3 A1 VSS VSS nmos_rvt w=46.0n l=16n nfin=2
MM8 n3 na1 Y VSS nmos_rvt w=46.0n l=16n nfin=2
MM9 n3 A2 Y VSS nmos_rvt w=46.0n l=16n nfin=2
.ENDS
