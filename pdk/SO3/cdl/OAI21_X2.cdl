.SUBCKT OAI21_X2 A1 A2 B VDD VSS ZN
MM5 VDD B ZN VDD pmos_rvt w=92.00n l=16n nfin=4
MM3 ZN A1 net7 VDD pmos_rvt w=92.00n l=16n nfin=4
MM4 VDD A2 net7 VDD pmos_rvt w=92.00n l=16n nfin=4
MM2 ZN B net0 VSS nmos_rvt w=92.00n l=16n nfin=4
MM0 VSS A1 net0 VSS nmos_rvt w=92.00n l=16n nfin=4
MM1 VSS A2 net0 VSS nmos_rvt w=92.00n l=16n nfin=4
.ENDS
