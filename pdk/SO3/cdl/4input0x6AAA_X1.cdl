.SUBCKT 4input0x6AAA_X1 A B C D VDD VSS Y
* Canonical: 0b0000000111111110
* Function: Y = binate [recursive NAND/NOR, 16 TR]
* Transistors: 16
MbdhP2 npbdh0 D VDD VDD pmos_rvt W=46.0n L=16n nfin=2
MbdhP3 npbdh1 C npbdh0 VDD pmos_rvt W=46.0n L=16n nfin=2
MbdhP4 bdh B npbdh1 VDD pmos_rvt W=46.0n L=16n nfin=2
MP111 bdcg A VDD VDD pmos_rvt W=46.0n L=16n nfin=2
MP112 bdcg bdh VDD VDD pmos_rvt W=46.0n L=16n nfin=2
MbdccP0 Y bdcg VDD VDD pmos_rvt W=46.0n L=16n nfin=2
MbdccP2 npbdcc1 bdh VDD VDD pmos_rvt W=46.0n L=16n nfin=2
MbdccP3 Y A npbdcc1 VDD pmos_rvt W=46.0n L=16n nfin=2
MbdhN0 bdh D VSS VSS nmos_rvt W=46.0n L=16n nfin=2
MbdhN1 bdh C VSS VSS nmos_rvt W=46.0n L=16n nfin=2
MbdhN2 bdh B VSS VSS nmos_rvt W=46.0n L=16n nfin=2
MN113 bdcg A bdcgs0 VSS nmos_rvt W=46.0n L=16n nfin=2
MN114 bdcgs0 bdh VSS VSS nmos_rvt W=46.0n L=16n nfin=2
MbdccN1 Y bdcg nsbdcc0 VSS nmos_rvt W=46.0n L=16n nfin=2
MbdccN2 nsbdcc0 bdh VSS VSS nmos_rvt W=46.0n L=16n nfin=2
MbdccN3 nsbdcc0 A VSS VSS nmos_rvt W=46.0n L=16n nfin=2
.ENDS
