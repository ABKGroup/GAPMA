.SUBCKT 4input0x8AA8_X2 A B C D VDD VSS Y
* Canonical: 0b0000000001101111
* Function: Y = binate [recursive NAND/NOR, 14 TR]
* Transistors: 14
MP0 bgp0 C VDD VDD pmos_rvt W=46.0n L=16n nfin=2
MP1 bg D bgp0 VDD pmos_rvt W=46.0n L=16n nfin=2
MbcP1 npbc0 B VDD VDD pmos_rvt W=92.0n L=16n nfin=4
MbcP3 npbc2 bg VDD VDD pmos_rvt W=92.0n L=16n nfin=4
MbcP4 npbc0 C npbc2 VDD pmos_rvt W=92.0n L=16n nfin=4
MbcP5 npbc0 D npbc2 VDD pmos_rvt W=92.0n L=16n nfin=4
MbcP6 Y A npbc0 VDD pmos_rvt W=92.0n L=16n nfin=4
MN2 bg C VSS VSS nmos_rvt W=46.0n L=16n nfin=2
MN3 bg D VSS VSS nmos_rvt W=46.0n L=16n nfin=2
MbcN1 Y B nsbc0 VSS nmos_rvt W=92.0n L=16n nfin=4
MbcN2 nsbc0 bg VSS VSS nmos_rvt W=92.0n L=16n nfin=4
MbcN4 nsbc0 C nsbc3 VSS nmos_rvt W=92.0n L=16n nfin=4
MbcN5 nsbc3 D VSS VSS nmos_rvt W=92.0n L=16n nfin=4
MbcN6 Y A VSS VSS nmos_rvt W=92.0n L=16n nfin=4
.ENDS
