.SUBCKT 3input0x4_X1 A1 A2 A3 VDD VSS Y
MM7 na3 A3 VSS VSS nmos_rvt w=46.0n l=16n nfin=2
MM6 na3 A3 VDD VDD pmos_rvt w=46.0n l=16n nfin=2
MM5 VSS A1 Y VSS nmos_rvt w=46.0n l=16n nfin=2
MM4 VSS A2 Y VSS nmos_rvt w=46.0n l=16n nfin=2
MM3 VSS na3 Y VSS nmos_rvt w=46.0n l=16n nfin=2
MM2 n2 A1 Y VDD pmos_rvt w=46.0n l=16n nfin=2
MM1 n1 A2 n2 VDD pmos_rvt w=46.0n l=16n nfin=2
MM0 VDD na3 n1 VDD pmos_rvt w=46.0n l=16n nfin=2
.ENDS
