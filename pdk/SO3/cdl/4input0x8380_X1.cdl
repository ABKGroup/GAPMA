.SUBCKT 4input0x8380_X1 A B C D VDD VSS Y
* Canonical: 0b0000000110001001
* Function: Y = binate [recursive NAND/NOR, 16 TR]
* Transistors: 16
MP0 bg C VDD VDD pmos_rvt W=46.0n L=16n nfin=2
MP1 bg D VDD VDD pmos_rvt W=46.0n L=16n nfin=2
MbcP1 npbc0 bg VDD VDD pmos_rvt W=46.0n L=16n nfin=2
MbcP4 npbc2 B VDD VDD pmos_rvt W=46.0n L=16n nfin=2
MbcP5 npbc3 C npbc2 VDD pmos_rvt W=46.0n L=16n nfin=2
MbcP6 npbc0 D npbc3 VDD pmos_rvt W=46.0n L=16n nfin=2
MbcP7 Y A npbc0 VDD pmos_rvt W=46.0n L=16n nfin=2
MbcP8 Y D npbc0 VDD pmos_rvt W=46.0n L=16n nfin=2
MN2 bg C bgs0 VSS nmos_rvt W=46.0n L=16n nfin=2
MN3 bgs0 D VSS VSS nmos_rvt W=46.0n L=16n nfin=2
MbcN1 Y bg nsbc0 VSS nmos_rvt W=46.0n L=16n nfin=2
MbcN2 nsbc0 B VSS VSS nmos_rvt W=46.0n L=16n nfin=2
MbcN3 nsbc0 C VSS VSS nmos_rvt W=46.0n L=16n nfin=2
MbcN4 nsbc0 D VSS VSS nmos_rvt W=46.0n L=16n nfin=2
MbcN6 Y A nsbc5 VSS nmos_rvt W=46.0n L=16n nfin=2
MbcN7 nsbc5 D VSS VSS nmos_rvt W=46.0n L=16n nfin=2
.ENDS
