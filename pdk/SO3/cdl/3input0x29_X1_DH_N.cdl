.SUBCKT 3input0x29_X1_DH_N A1 A2 A3 VDD VSS Y
MM0 VSS A1 nor2 VSS nmos_rvt w=46.0n l=16n nfin=2
MM1 VSS A2 nor2 VSS nmos_rvt w=46.0n l=16n nfin=2
MM2 n1 A2 nor2 VDD pmos_rvt w=46.0n l=16n nfin=2
MM3 VDD A1 n1 VDD pmos_rvt w=46.0n l=16n nfin=2
MM4 n2 A1 VSS VSS nmos_rvt w=46.0n l=16n nfin=2
MM5 n3 A3 n2 VSS nmos_rvt w=46.0n l=16n nfin=2
MM6 nand3 A2 n3 VSS nmos_rvt w=46.0n l=16n nfin=2
MM7 nand3 A3 VDD VDD pmos_rvt w=46.0n l=16n nfin=2
MM8 nand3 A2 VDD VDD pmos_rvt w=46.0n l=16n nfin=2
MM9 nand3 A1 VDD VDD pmos_rvt w=46.0n l=16n nfin=2
MM10 n4 A2 VSS VSS nmos_rvt w=46.00n l=16n nfin=2
MM11 n4 A1 n7 VSS nmos_rvt w=46.00n l=16n nfin=2
MM12 n7 A3 VSS VSS nmos_rvt w=46.00n l=16n nfin=2
MM13 n7 nor2 VSS VSS nmos_rvt w=46.00n l=16n nfin=2
MM19 Y nand3 n7 VSS nmos_rvt w=46.00n l=16n nfin=2
MM14 n5 A1 Y VDD pmos_rvt w=46.00n l=16n nfin=2
MM15 n5 A2 Y VDD pmos_rvt w=46.00n l=16n nfin=2
MM16 n5 nor2 n6 VDD pmos_rvt w=46.00n l=16n nfin=2
MM17 VDD A3 n6 VDD pmos_rvt w=46.00n l=16n nfin=2
MM18 Y nand3 VDD VDD pmos_rvt w=46.00n l=16n nfin=2
.ENDS
