.SUBCKT 3input0x39_X2 A1 A2 A3 VDD VSS Y
MM5 VDD A3 Y VDD pmos_rvt w=92.00n l=16n nfin=4
MM3 VDD A2 n1 VDD pmos_rvt w=92.00n l=16n nfin=4
MM4 Y na1 n1 VDD pmos_rvt w=92.00n l=16n nfin=4
MM2 VSS A3 n2 VSS nmos_rvt w=92.00n l=16n nfin=4
MM0 Y na1 n2 VSS nmos_rvt w=92.00n l=16n nfin=4
MM1 Y A2 n2 VSS nmos_rvt w=92.00n l=16n nfin=4
MM6 na1 A1 VSS VSS nmos_rvt w=92.0n l=16n nfin=4
MM7 na1 A1 VDD VDD pmos_rvt w=92.0n l=16n nfin=4
.ENDS
