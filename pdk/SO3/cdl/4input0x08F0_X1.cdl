.SUBCKT 4input0x08F0_X1 A B C D VDD VSS Y
* Canonical: 0b0000000110101010
* Function: Y = binate [recursive NAND/NOR, 14 TR]
* Transistors: 14
MP0 bgp0 A VDD VDD pmos_rvt W=46.0n L=16n nfin=2
MP1 bg D bgp0 VDD pmos_rvt W=46.0n L=16n nfin=2
MbcP1 npbc0 A VDD VDD pmos_rvt W=46.0n L=16n nfin=2
MbcP4 npbc2 D VDD VDD pmos_rvt W=46.0n L=16n nfin=2
MbcP5 npbc3 C npbc2 VDD pmos_rvt W=46.0n L=16n nfin=2
MbcP6 npbc0 B npbc3 VDD pmos_rvt W=46.0n L=16n nfin=2
MbcP7 Y bg npbc0 VDD pmos_rvt W=46.0n L=16n nfin=2
MN2 bg A VSS VSS nmos_rvt W=46.0n L=16n nfin=2
MN3 bg D VSS VSS nmos_rvt W=46.0n L=16n nfin=2
MbcN1 Y A nsbc0 VSS nmos_rvt W=46.0n L=16n nfin=2
MbcN2 nsbc0 D VSS VSS nmos_rvt W=46.0n L=16n nfin=2
MbcN3 nsbc0 C VSS VSS nmos_rvt W=46.0n L=16n nfin=2
MbcN4 nsbc0 B VSS VSS nmos_rvt W=46.0n L=16n nfin=2
MbcN5 Y bg VSS VSS nmos_rvt W=46.0n L=16n nfin=2
.ENDS
