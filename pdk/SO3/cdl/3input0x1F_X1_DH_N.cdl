.SUBCKT 3input0x1F_X1_DH_N A1 A2 A3 VDD VSS Y
MM3 VSS A3 nor2 VSS nmos_rvt w=46.0n l=16n nfin=2
MM2 VSS A2 nor2 VSS nmos_rvt w=46.0n l=16n nfin=2
MM1 n1 A2 nor2 VDD pmos_rvt w=46.0n l=16n nfin=2
MM0 VDD A3 n1 VDD pmos_rvt w=46.0n l=16n nfin=2
MM5 na1 A1 VSS VSS nmos_rvt w=46.0n l=16n nfin=2
MM4 na1 A1 VDD VDD pmos_rvt w=46.0n l=16n nfin=2
MM8 VDD A2 n2 VDD pmos_rvt w=46.0n l=16n nfin=2
MM9 VDD A3 n2 VDD pmos_rvt w=46.0n l=16n nfin=2
MM6 Y nor2 n2 VDD pmos_rvt w=46.0n l=16n nfin=2
MM7 VDD na1 Y VDD pmos_rvt w=46.0n l=16n nfin=2
MM10 n3 na1 VSS VSS nmos_rvt w=46.0n l=16n nfin=2
MM11 n3 nor2 Y VSS nmos_rvt w=46.0n l=16n nfin=2
MM12 n3 A2 n4 VSS nmos_rvt w=46.0n l=16n nfin=2
MM13 Y A3 n4 VSS nmos_rvt w=46.0n l=16n nfin=2
.ENDS
