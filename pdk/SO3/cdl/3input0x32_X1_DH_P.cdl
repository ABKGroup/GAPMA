.SUBCKT 3input0x32_X1_DH_P A1 A2 A3 VDD VSS Y
MM5 aoi21 A1 VSS VSS nmos_rvt w=46.00n l=16n nfin=2
MM4 n2 A2 aoi21 VSS nmos_rvt w=46.00n l=16n nfin=2
MM3 n2 A3 VSS VSS nmos_rvt w=46.00n l=16n nfin=2
MM2 n1 A1 VDD VDD pmos_rvt w=46.00n l=16n nfin=2
MM1 n1 A2 aoi21 VDD pmos_rvt w=46.00n l=16n nfin=2
MM0 n1 A3 aoi21 VDD pmos_rvt w=46.00n l=16n nfin=2
MM6 n3 A3 VDD VDD pmos_rvt w=46.00n l=16n nfin=2
MM7 n3 A2 VDD VDD pmos_rvt w=46.00n l=16n nfin=2
MM8 n3 A1 VDD VDD pmos_rvt w=46.00n l=16n nfin=2
MM9 n3 aoi21 Y VDD pmos_rvt w=46.00n l=16n nfin=2
MM10 n3 A2 n4 VDD pmos_rvt w=46.00n l=16n nfin=2
MM11 Y A3 n4 VDD pmos_rvt w=46.00n l=16n nfin=2
MM13 n5 A1 VSS VSS nmos_rvt w=46.00n l=16n nfin=2
MM14 n5 A2 n6 VSS nmos_rvt w=46.00n l=16n nfin=2
MM15 Y A3 n6 VSS nmos_rvt w=46.00n l=16n nfin=2
MM16 n7 A2 VSS VSS nmos_rvt w=46.00n l=16n nfin=2
MM17 n7 A3 VSS VSS nmos_rvt w=46.00n l=16n nfin=2
MM12 n7 aoi21 Y VSS nmos_rvt w=46.00n l=16n nfin=2
.ENDS
