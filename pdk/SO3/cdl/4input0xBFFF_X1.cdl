4input0xBFFF_X1

4input0xBFFF_X1

.SUBCKT 4input0xBFFF_X1 A B C D VDD VSS Y
** N=11 EP=7 FDC=10
M0 Y A VDD VDD pmos_rvt L=1.6e-08 W=4.6e-08 nfin=2 $X=148 $Y=340 $dt=0
M1 VDD 4 Y VDD pmos_rvt L=1.6e-08 W=4.6e-08 nfin=2 $X=328 $Y=340 $dt=0
M2 10 B VDD VDD pmos_rvt L=1.6e-08 W=4.6e-08 nfin=2 $X=508 $Y=340 $dt=0
M3 9 C 10 VDD pmos_rvt L=1.6e-08 W=4.6e-08 nfin=2 $X=688 $Y=340 $dt=0
M4 4 D 9 VDD pmos_rvt L=1.6e-08 W=4.6e-08 nfin=2 $X=868 $Y=340 $dt=0
M5 11 A Y VSS nmos_rvt L=1.6e-08 W=4.6e-08 nfin=2 $X=148 $Y=52 $dt=1
M6 VSS 4 11 VSS nmos_rvt L=1.6e-08 W=4.6e-08 nfin=2 $X=328 $Y=52 $dt=1
M7 4 B VSS VSS nmos_rvt L=1.6e-08 W=4.6e-08 nfin=2 $X=508 $Y=52 $dt=1
M8 VSS C 4 VSS nmos_rvt L=1.6e-08 W=4.6e-08 nfin=2 $X=688 $Y=52 $dt=1
M9 4 D VSS VSS nmos_rvt L=1.6e-08 W=4.6e-08 nfin=2 $X=868 $Y=52 $dt=1
.ends 4input0xBFFF_X1
