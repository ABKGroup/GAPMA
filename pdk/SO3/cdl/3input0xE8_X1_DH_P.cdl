.SUBCKT 3input0xE8_X1_DH_P A1 A2 A3 VDD VSS Y
MM0 n2 A1 Y VDD pmos_rvt w=46.0n l=16n nfin=2
MM1 n2 A2 Y VDD pmos_rvt w=46.0n l=16n nfin=2
MM2 n2 A3 VDD VDD pmos_rvt w=46.0n l=16n nfin=2
MM3 VDD A1 n1 VDD pmos_rvt w=46.0n l=16n nfin=2
MM4 Y A2 n1 VDD pmos_rvt w=46.0n l=16n nfin=2
MM5 n3 A1 VSS VSS nmos_rvt w=46.0n l=16n nfin=2
MM6 n3 A2 n4 VSS nmos_rvt w=46.0n l=16n nfin=2
MM7 n4 A3 VSS VSS nmos_rvt w=46.0n l=16n nfin=2
MM8 n4 A1 Y VSS nmos_rvt w=46.0n l=16n nfin=2
MM9 n4 A2 Y VSS nmos_rvt w=46.0n l=16n nfin=2
.ENDS
