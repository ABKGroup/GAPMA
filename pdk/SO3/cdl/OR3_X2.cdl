.SUBCKT OR3_X2 A1 A2 A3 VDD VSS Z
MM7 Z net2 VSS VSS nmos_rvt w=92.0n l=16n nfin=4
MM6 VSS A1 net2 VSS nmos_rvt w=46.0n l=16n nfin=2
MM5 VSS A2 net2 VSS nmos_rvt w=46.0n l=16n nfin=2
MM4 VSS A3 net2 VSS nmos_rvt w=46.0n l=16n nfin=2
MM3 Z net2 VDD VDD pmos_rvt w=92.0n l=16n nfin=4
MM2 net2 A2 net6 VDD pmos_rvt w=46.0n l=16n nfin=2
MM1 net7 A3 net6 VDD pmos_rvt w=46.0n l=16n nfin=2
MM0 VDD A1 net7 VDD pmos_rvt w=46.0n l=16n nfin=2
.ENDS
