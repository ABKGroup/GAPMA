.SUBCKT 3input0x1C_X1_DH_N A1 A2 A3 VDD VSS Y
MM5 VSS A1 nor3 VSS nmos_rvt w=46.0n l=16n nfin=2
MM4 VSS A2 nor3 VSS nmos_rvt w=46.0n l=16n nfin=2
MM3 VSS A3 nor3 VSS nmos_rvt w=46.0n l=16n nfin=2
MM2 n2 A3 nor3 VDD pmos_rvt w=46.0n l=16n nfin=2
MM1 n1 A2 n2 VDD pmos_rvt w=46.0n l=16n nfin=2
MM0 VDD A1 n1 VDD pmos_rvt w=46.0n l=16n nfin=2
MM6 VDD A3 n3 VDD pmos_rvt w=46.0n l=16n nfin=2
MM7 VDD A2 n4 VDD pmos_rvt w=46.0n l=16n nfin=2
MM8 n4 A1 n3 VDD pmos_rvt w=46.0n l=16n nfin=2
MM9 Y nor3 n3 VDD pmos_rvt w=46.0n l=16n nfin=2
MM10 VSS nor3 Y VSS nmos_rvt w=46.0n l=16n nfin=2
MM11 VSS A1 n5 VSS nmos_rvt w=46.0n l=16n nfin=2
MM12 VSS A2 n5 VSS nmos_rvt w=46.0n l=16n nfin=2
MM13 Y A3 n5 VSS nmos_rvt w=46.0n l=16n nfin=2
.ENDS
