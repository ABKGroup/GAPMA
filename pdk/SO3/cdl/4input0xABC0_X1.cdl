.SUBCKT 4input0xABC0_X1 A B C D VDD VSS Y
* Canonical: 0b0000001111010101
* Function: Y = binate [recursive NAND/NOR, 16 TR]
* Transistors: 16
MP3 bgpa A VDD VDD pmos_rvt W=46.0n L=16n nfin=2
MP4 bg B bgpa VDD pmos_rvt W=46.0n L=16n nfin=2
MP5 bg C bgpa VDD pmos_rvt W=46.0n L=16n nfin=2
MbcP1 npbc0 A VDD VDD pmos_rvt W=46.0n L=16n nfin=2
MbcP3 npbc2 C VDD VDD pmos_rvt W=46.0n L=16n nfin=2
MbcP4 npbc0 B npbc2 VDD pmos_rvt W=46.0n L=16n nfin=2
MbcP5 Y D npbc0 VDD pmos_rvt W=46.0n L=16n nfin=2
MbcP6 Y bg npbc0 VDD pmos_rvt W=46.0n L=16n nfin=2
MN0 bg A VSS VSS nmos_rvt W=46.0n L=16n nfin=2
MN1 bg B bgnb VSS nmos_rvt W=46.0n L=16n nfin=2
MN2 bgnb C VSS VSS nmos_rvt W=46.0n L=16n nfin=2
MbcN1 Y A nsbc0 VSS nmos_rvt W=46.0n L=16n nfin=2
MbcN2 nsbc0 C VSS VSS nmos_rvt W=46.0n L=16n nfin=2
MbcN3 nsbc0 B VSS VSS nmos_rvt W=46.0n L=16n nfin=2
MbcN5 Y D nsbc4 VSS nmos_rvt W=46.0n L=16n nfin=2
MbcN6 nsbc4 bg VSS VSS nmos_rvt W=46.0n L=16n nfin=2
.ENDS
