* +++++++++++++++++++++++++++++++++++++++++++++++++++++++++ *
* CDL Netlist:                                              *
*                                                           *
* Cell Name  : 4input0x000EA_X1                        *
* Netlisted  : Sat May 23 01:04:48 2026                     *
* Pegasus Version: 21.31-s008 Thu Jan 13 15:55:10 PST 2022  *
* +++++++++++++++++++++++++++++++++++++++++++++++++++++++++ *
*.LDD

* +++++++++++++++++++++++++++++++++++++++++++++++++++++++++ *
* Sub cell: 4input0x000EA_X1                           *
* +++++++++++++++++++++++++++++++++++++++++++++++++++++++++ *
.subckt 4input0x000EA_X1 A B C D VDD VSS Y
** N=11 EP=7 FDC=10
M0 Y C 9 VDD pmos_rvt L=1.6e-08 W=4.6e-08 nfin=2 $X=148 $Y=340
M1 9 4 Y VDD pmos_rvt L=1.6e-08 W=4.6e-08 nfin=2 $X=328 $Y=340
M2 VDD D 9 VDD pmos_rvt L=1.6e-08 W=4.6e-08 nfin=2 $X=508 $Y=340
M3 4 A VDD VDD pmos_rvt L=1.6e-08 W=4.6e-08 nfin=2 $X=688 $Y=340
M4 VDD B 4 VDD pmos_rvt L=1.6e-08 W=4.6e-08 nfin=2 $X=868 $Y=340
M5 11 C VSS VSS nmos_rvt L=1.6e-08 W=4.6e-08 nfin=2 $X=148 $Y=52
M6 Y 4 11 VSS nmos_rvt L=1.6e-08 W=4.6e-08 nfin=2 $X=328 $Y=52
M7 VSS D Y VSS nmos_rvt L=1.6e-08 W=4.6e-08 nfin=2 $X=508 $Y=52
M8 10 A VSS VSS nmos_rvt L=1.6e-08 W=4.6e-08 nfin=2 $X=688 $Y=52
M9 4 B 10 VSS nmos_rvt L=1.6e-08 W=4.6e-08 nfin=2 $X=868 $Y=52
.ends 4input0x000EA_X1
