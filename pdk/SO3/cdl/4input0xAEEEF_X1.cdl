* +++++++++++++++++++++++++++++++++++++++++++++++++++++++++ *
* CDL Netlist:                                              *
*                                                           *
* Cell Name  : 4input0xAEEEF_X1                        *
* Netlisted  : Sat May 23 01:05:07 2026                     *
* Pegasus Version: 21.31-s008 Thu Jan 13 15:55:10 PST 2022  *
* +++++++++++++++++++++++++++++++++++++++++++++++++++++++++ *
*.LDD

* +++++++++++++++++++++++++++++++++++++++++++++++++++++++++ *
* Sub cell: 4input0xAEEEF_X1                           *
* +++++++++++++++++++++++++++++++++++++++++++++++++++++++++ *
.subckt 4input0xAEEEF_X1 A B C D VDD VSS Y
** N=11 EP=7 FDC=10
M0 VDD B Y VDD pmos_rvt L=1.6e-08 W=4.6e-08 nfin=2 $X=148 $Y=340
M1 Y A VDD VDD pmos_rvt L=1.6e-08 W=4.6e-08 nfin=2 $X=328 $Y=340
M2 VDD 3 Y VDD pmos_rvt L=1.6e-08 W=4.6e-08 nfin=2 $X=508 $Y=340
M3 9 D VDD VDD pmos_rvt L=1.6e-08 W=4.6e-08 nfin=2 $X=688 $Y=340
M4 3 C 9 VDD pmos_rvt L=1.6e-08 W=4.6e-08 nfin=2 $X=868 $Y=340
M5 11 B Y VSS nmos_rvt L=1.6e-08 W=4.6e-08 nfin=2 $X=148 $Y=52
M6 10 A 11 VSS nmos_rvt L=1.6e-08 W=4.6e-08 nfin=2 $X=328 $Y=52
M7 VSS 3 10 VSS nmos_rvt L=1.6e-08 W=4.6e-08 nfin=2 $X=508 $Y=52
M8 3 D VSS VSS nmos_rvt L=1.6e-08 W=4.6e-08 nfin=2 $X=688 $Y=52
M9 VSS C 3 VSS nmos_rvt L=1.6e-08 W=4.6e-08 nfin=2 $X=868 $Y=52
.ends 4input0xAEEEF_X1
