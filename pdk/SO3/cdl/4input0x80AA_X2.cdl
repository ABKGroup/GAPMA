.SUBCKT 4input0x80AA_X2 A B C D VDD VSS Y
* Canonical: 0b1000000010101010
* Function: Y = binate [small-gate search, 12 TR]
* Transistors: 12
MP0 sg4_ps0 B VDD VDD pmos_rvt W=92.0n L=16n nfin=4
MP1 sg4 C sg4_ps0 VDD pmos_rvt W=92.0n L=16n nfin=4
MP4 sg6_ps0 A VDD VDD pmos_rvt W=92.0n L=16n nfin=4
MP5 sg6 sg4 sg6_ps0 VDD pmos_rvt W=92.0n L=16n nfin=4
MP8 sg8_ps0 D VDD VDD pmos_rvt W=92.0n L=16n nfin=4
MP9 Y sg6 sg8_ps0 VDD pmos_rvt W=92.0n L=16n nfin=4
MN2 sg4 B VSS VSS nmos_rvt W=92.0n L=16n nfin=4
MN3 sg4 C VSS VSS nmos_rvt W=92.0n L=16n nfin=4
MN6 sg6 A VSS VSS nmos_rvt W=92.0n L=16n nfin=4
MN7 sg6 sg4 VSS VSS nmos_rvt W=92.0n L=16n nfin=4
MN10 Y D VSS VSS nmos_rvt W=92.0n L=16n nfin=4
MN11 Y sg6 VSS VSS nmos_rvt W=92.0n L=16n nfin=4
.ENDS
