.SUBCKT 3input0xEF_X1 A1 A2 A3 VDD VSS Y
MM0 na1 A1 VSS VSS nmos_rvt w=46.0n l=16n nfin=2
MM1 na1 A1 VDD VDD pmos_rvt w=46.0n l=16n nfin=2
MM5 n2 na1 VSS VSS nmos_rvt w=46.0n l=16n nfin=2
MM4 n1 A3 n2 VSS nmos_rvt w=46.0n l=16n nfin=2
MM3 Y A2 n1 VSS nmos_rvt w=46.0n l=16n nfin=2
MM2 Y A3 VDD VDD pmos_rvt w=46.0n l=16n nfin=2
MM7 Y A2 VDD VDD pmos_rvt w=46.0n l=16n nfin=2
MM6 Y na1 VDD VDD pmos_rvt w=46.0n l=16n nfin=2
.ENDS
