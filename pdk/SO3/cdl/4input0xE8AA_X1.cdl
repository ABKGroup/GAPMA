.SUBCKT 4input0xE8AA_X1 A B C D VDD VSS Y
* Canonical: 0b0000000110111111
* Function: Y = binate [recursive NAND/NOR, 16 TR]
* Transistors: 16
MP0 bg D VDD VDD pmos_rvt W=46.0n L=16n nfin=2
MbcP1 npbc0 A VDD VDD pmos_rvt W=46.0n L=16n nfin=2
MbcP4 npbc2 D VDD VDD pmos_rvt W=46.0n L=16n nfin=2
MbcP5 npbc3 C npbc2 VDD pmos_rvt W=46.0n L=16n nfin=2
MbcP6 npbc0 B npbc3 VDD pmos_rvt W=46.0n L=16n nfin=2
MbcP7 Y B npbc0 VDD pmos_rvt W=46.0n L=16n nfin=2
MbcP8 Y C npbc0 VDD pmos_rvt W=46.0n L=16n nfin=2
MbcP9 Y bg npbc0 VDD pmos_rvt W=46.0n L=16n nfin=2
MN1 bg D VSS VSS nmos_rvt W=46.0n L=16n nfin=2
MbcN1 Y A nsbc0 VSS nmos_rvt W=46.0n L=16n nfin=2
MbcN2 nsbc0 D VSS VSS nmos_rvt W=46.0n L=16n nfin=2
MbcN3 nsbc0 C VSS VSS nmos_rvt W=46.0n L=16n nfin=2
MbcN4 nsbc0 B VSS VSS nmos_rvt W=46.0n L=16n nfin=2
MbcN7 Y B nsbc5 VSS nmos_rvt W=46.0n L=16n nfin=2
MbcN8 nsbc5 C nsbc6 VSS nmos_rvt W=46.0n L=16n nfin=2
MbcN9 nsbc6 bg VSS VSS nmos_rvt W=46.0n L=16n nfin=2
.ENDS
