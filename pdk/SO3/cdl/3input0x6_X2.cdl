.SUBCKT 3input0x6_X2 A1 A2 A3 VDD VSS Y
MM5 VDD A3 oai21 VDD pmos_rvt w=46.00n l=16n nfin=2
MM3 oai21 A1 n1 VDD pmos_rvt w=46.00n l=16n nfin=2
MM4 VDD A2 n1 VDD pmos_rvt w=46.00n l=16n nfin=2
MM2 VSS A3 n2 VSS nmos_rvt w=46.00n l=16n nfin=2
MM0 oai21 A1 n2 VSS nmos_rvt w=46.00n l=16n nfin=2
MM1 oai21 A2 n2 VSS nmos_rvt w=46.00n l=16n nfin=2
MM11 Y oai21 VSS VSS nmos_rvt w=92.0n l=16n nfin=4
MM10 n4 A1 Y VSS nmos_rvt w=92.0n l=16n nfin=4
MM9 n4 A2 VSS VSS nmos_rvt w=92.0n l=16n nfin=4
MM8 n3 oai21 VDD VDD pmos_rvt w=92.0n l=16n nfin=4
MM7 n3 A1 Y VDD pmos_rvt w=92.0n l=16n nfin=4
MM6 n3 A2 Y VDD pmos_rvt w=92.0n l=16n nfin=4
.ENDS
