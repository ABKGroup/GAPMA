4input0xEAFF_X1

4input0xEAFF_X1

.SUBCKT 4input0xEAFF_X1 A B C D VDD VSS Y
** N=11 EP=7 FDC=10
M0 10 C Y VDD pmos_rvt L=1.6e-08 W=4.6e-08 nfin=2 $X=148 $Y=340 $dt=0
M1 VDD A Y VDD pmos_rvt L=1.6e-08 W=4.6e-08 nfin=2 $X=148 $Y=628 $dt=0
M2 VDD B 10 VDD pmos_rvt L=1.6e-08 W=4.6e-08 nfin=2 $X=328 $Y=340 $dt=0
M3 Y 3 VDD VDD pmos_rvt L=1.6e-08 W=4.6e-08 nfin=2 $X=328 $Y=628 $dt=0
M4 3 D VDD VDD pmos_rvt L=1.6e-08 W=4.6e-08 nfin=2 $X=508 $Y=340 $dt=0
M5 9 C VSS VSS nmos_rvt L=1.6e-08 W=4.6e-08 nfin=2 $X=148 $Y=52 $dt=1
M6 11 A 9 VSS nmos_rvt L=1.6e-08 W=4.6e-08 nfin=2 $X=148 $Y=916 $dt=1
M7 VSS B 9 VSS nmos_rvt L=1.6e-08 W=4.6e-08 nfin=2 $X=328 $Y=52 $dt=1
M8 Y 3 11 VSS nmos_rvt L=1.6e-08 W=4.6e-08 nfin=2 $X=328 $Y=916 $dt=1
M9 3 D VSS VSS nmos_rvt L=1.6e-08 W=4.6e-08 nfin=2 $X=508 $Y=52 $dt=1
.ends 4input0xEAFF_X1
