.SUBCKT 3input0xA9_X1_DH_P A1 A2 A3 VDD VSS Y
MM5 n2 A3 VSS VSS nmos_rvt w=46.0n l=16n nfin=2
MM4 n1 A1 n2 VSS nmos_rvt w=46.0n l=16n nfin=2
MM3 nand3 A2 n1 VSS nmos_rvt w=46.0n l=16n nfin=2
MM2 nand3 A3 VDD VDD pmos_rvt w=46.0n l=16n nfin=2
MM1 nand3 A2 VDD VDD pmos_rvt w=46.0n l=16n nfin=2
MM0 nand3 A1 VDD VDD pmos_rvt w=46.0n l=16n nfin=2
MM6 n3 A1 VDD VDD pmos_rvt w=46.0n l=16n nfin=2
MM7 n3 A2 VDD VDD pmos_rvt w=46.0n l=16n nfin=2
MM8 n3 A3 Y VDD pmos_rvt w=46.0n l=16n nfin=2
MM9 Y nand3 VDD VDD pmos_rvt w=46.0n l=16n nfin=2
MM10 n4 nand3 VSS VSS nmos_rvt w=46.0n l=16n nfin=2
MM11 n4 A3 Y VSS nmos_rvt w=46.0n l=16n nfin=2
MM12 n4 A1 n5 VSS nmos_rvt w=46.0n l=16n nfin=2
MM13 Y A2 n5 VSS nmos_rvt w=46.0n l=16n nfin=2
.ENDS
