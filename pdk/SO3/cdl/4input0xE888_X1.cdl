* selected_from: 4input0xF880_X1_spv5_ssv11
* source_file: ck_server/moore/final.cdl
* ck_server_log: ck_server/moore/notopo_dummy0_parallel/4input0xF880_X1/4input0xF880_X1_spv5_ssv11_notopo_dummy0.full.log
* dummy_for_ideal: 0
* width_cols: 13
* transistor_count: 12
* objective: 336.0
* via_count: 0
.SUBCKT 4input0xE888_X1 A1 A2 A3 A4 VDD VSS Y
MM0 p2 A1 VDD VDD pmos_rvt w=46.0n l=16n nfin=2
MM1 p1 A2 p2 VDD pmos_rvt w=46.0n l=16n nfin=2
MM2 p3 A4 VDD VDD pmos_rvt w=46.0n l=16n nfin=2
MM3 p1 A3 p3 VDD pmos_rvt w=46.0n l=16n nfin=2
MM4 Y A1 p1 VDD pmos_rvt w=46.0n l=16n nfin=2
MM5 Y A2 p1 VDD pmos_rvt w=46.0n l=16n nfin=2
MM6 n1 A1 Y VSS nmos_rvt w=46.0n l=16n nfin=2
MM7 n1 A2 Y VSS nmos_rvt w=46.0n l=16n nfin=2
MM8 VSS A3 n1 VSS nmos_rvt w=46.0n l=16n nfin=2
MM9 VSS A4 n1 VSS nmos_rvt w=46.0n l=16n nfin=2
MM10 n2 A2 n1 VSS nmos_rvt w=46.0n l=16n nfin=2
MM11 VSS A1 n2 VSS nmos_rvt w=46.0n l=16n nfin=2
.ENDS 4input0xE888_X1
