.SUBCKT 4input0x888A_X2 A B C D VDD VSS Y
* Canonical: 0b1000100010001010
* Function: Y = binate [small-gate search, 10 TR]
* Transistors: 10
MP0 sg4 A VDD VDD pmos_rvt W=92.0n L=16n nfin=4
MP1 sg4 B VDD VDD pmos_rvt W=92.0n L=16n nfin=4
MP7 sg6_pmid D VDD VDD pmos_rvt W=92.0n L=16n nfin=4
MP8 Y C sg6_pmid VDD pmos_rvt W=92.0n L=16n nfin=4
MP9 Y sg4 sg6_pmid VDD pmos_rvt W=92.0n L=16n nfin=4
MN2 sg4 A sg4_ns0 VSS nmos_rvt W=92.0n L=16n nfin=4
MN3 sg4_ns0 B VSS VSS nmos_rvt W=92.0n L=16n nfin=4
MN4 Y D VSS VSS nmos_rvt W=92.0n L=16n nfin=4
MN5 Y C sg6_nmid VSS nmos_rvt W=92.0n L=16n nfin=4
MN6 sg6_nmid sg4 VSS VSS nmos_rvt W=92.0n L=16n nfin=4
.ENDS
