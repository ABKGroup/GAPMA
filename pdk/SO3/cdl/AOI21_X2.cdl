.SUBCKT AOI21_X2 A1 A2 B VDD VSS ZN
MM5 VSS B ZN VSS nmos_rvt w=92.00n l=16n nfin=4
MM4 ZN A1 net2 VSS nmos_rvt w=92.00n l=16n nfin=4
MM3 VSS A2 net2 VSS nmos_rvt w=92.00n l=16n nfin=4
MM2 ZN B net6 VDD pmos_rvt w=92.00n l=16n nfin=4
MM1 VDD A1 net6 VDD pmos_rvt w=92.00n l=16n nfin=4
MM0 VDD A2 net6 VDD pmos_rvt w=92.00n l=16n nfin=4
.ENDS
