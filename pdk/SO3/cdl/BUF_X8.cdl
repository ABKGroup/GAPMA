.SUBCKT BUF_X8 I VDD VSS Z
MM3 Z in VSS VSS nmos_rvt w=368.0n l=16n nfin=16
MM2 in I VSS VSS nmos_rvt w=184.0n l=16n nfin=8
MM0 Z in VDD VDD pmos_rvt w=368.0n l=16n nfin=16
MM1 in I VDD VDD pmos_rvt w=184.0n l=16n nfin=8
.ENDS
