.SUBCKT 2BDFFHQN_X1_SH CLK D0 D1 VDD VSS QN0 QN1
MM20 net3 CLK VSS VSS nmos_rvt w=46.0n l=16n nfin=2
MM21 net3 CLK VDD VDD pmos_rvt w=46.0n l=16n nfin=2
MM23 net4 net3 VSS VSS nmos_rvt w=46.0n l=16n nfin=2
MM22 net4 net3 VDD VDD pmos_rvt w=46.0n l=16n nfin=2
MM4_2 net10 net3 net12 VSS nmos_rvt w=46.0n l=16n nfin=2
MM5_2 VSS D0 net12 VSS nmos_rvt w=46.0n l=16n nfin=2
MM3_2 VDD D0 net16 VDD pmos_rvt w=46.0n l=16n nfin=2
MM1_2 net10 net4 net16 VDD pmos_rvt w=46.0n l=16n nfin=2
MM6_2 VSS net10 net8 VSS nmos_rvt w=46.0n l=16n nfin=2
MM7_2 VDD net10 net8 VDD pmos_rvt w=46.0n l=16n nfin=2
MM10_2 net10 net3 net15 VDD pmos_rvt w=46.0n l=16n nfin=2
MM11_2 VDD net8 net15 VDD pmos_rvt w=46.0n l=16n nfin=2
MM8_2 VSS net8 net9 VSS nmos_rvt w=46.0n l=16n nfin=2
MM9_2 net10 net4 net9 VSS nmos_rvt w=46.0n l=16n nfin=2
MM13_2 net8 net3 net1 VDD pmos_rvt w=46.0n l=16n nfin=2
MM12_2 net8 net4 net1 VSS nmos_rvt w=46.0n l=16n nfin=2
MM14_2 net7 net1 VSS VSS nmos_rvt w=46.0n l=16n nfin=2
MM15_2 net7 net1 VDD VDD pmos_rvt w=46.0n l=16n nfin=2
MM16_2 VSS net7 net6 VSS nmos_rvt w=46.0n l=16n nfin=2
MM17_2 net1 net3 net6 VSS nmos_rvt w=46.0n l=16n nfin=2
MM18_2 net1 net4 net14 VDD pmos_rvt w=46.0n l=16n nfin=2
MM19_2 VDD net7 net14 VDD pmos_rvt w=46.0n l=16n nfin=2
MM24_2 QN0 net1 VSS VSS nmos_rvt w=46.0n l=16n nfin=2
MM25_2 QN0 net1 VDD VDD pmos_rvt w=46.0n l=16n nfin=2
MM4_1 net10_1 net3 net12_1 VSS nmos_rvt w=46.0n l=16n nfin=2
MM5_1 VSS D1 net12_1 VSS nmos_rvt w=46.0n l=16n nfin=2
MM3_1 VDD D1 net16_1 VDD pmos_rvt w=46.0n l=16n nfin=2
MM1_1 net10_1 net4 net16_1 VDD pmos_rvt w=46.0n l=16n nfin=2
MM6_1 VSS net10_1 net8_1 VSS nmos_rvt w=46.0n l=16n nfin=2
MM7_1 VDD net10_1 net8_1 VDD pmos_rvt w=46.0n l=16n nfin=2
MM10_1 net10_1 net3 net15_1 VDD pmos_rvt w=46.0n l=16n nfin=2
MM11_1 VDD net8_1 net15_1 VDD pmos_rvt w=46.0n l=16n nfin=2
MM8_1 VSS net8_1 net9_1 VSS nmos_rvt w=46.0n l=16n nfin=2
MM9_1 net10_1 net4 net9_1 VSS nmos_rvt w=46.0n l=16n nfin=2
MM13_1 net8_1 net3 net1_1 VDD pmos_rvt w=46.0n l=16n nfin=2
MM12_1 net8_1 net4 net1_1 VSS nmos_rvt w=46.0n l=16n nfin=2
MM14_1 net7_1 net1_1 VSS VSS nmos_rvt w=46.0n l=16n nfin=2
MM15_1 net7_1 net1_1 VDD VDD pmos_rvt w=46.0n l=16n nfin=2
MM16_1 VSS net7_1 net6_1 VSS nmos_rvt w=46.0n l=16n nfin=2
MM17_1 net1_1 net3 net6_1 VSS nmos_rvt w=46.0n l=16n nfin=2
MM18_1 net1_1 net4 net14_1 VDD pmos_rvt w=46.0n l=16n nfin=2
MM19_1 VDD net7_1 net14_1 VDD pmos_rvt w=46.0n l=16n nfin=2
MM24_1 QN1 net1_1 VSS VSS nmos_rvt w=46.0n l=16n nfin=2
MM25_1 QN1 net1_1 VDD VDD pmos_rvt w=46.0n l=16n nfin=2
.ENDS
