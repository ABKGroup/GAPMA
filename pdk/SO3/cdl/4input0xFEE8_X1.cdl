* selected_from: 4input0xFEE8_X1_spv389
* source_file: ck_server/moore/final.cdl
* ck_server_log: ck_server/moore/notopo_dummy0_parallel/4input0xFEE8_X1/4input0xFEE8_X1_spv389_notopo_dummy0.full.log
* dummy_for_ideal: 0
* width_cols: 17
* transistor_count: 16
* objective: 803.0
* via_count: 0
.SUBCKT 4input0xFEE8_X1 A1 A2 A3 A4 VDD VSS Y
MM0 p1 A1 VDD VDD pmos_rvt w=46.0n l=16n nfin=2
MM1 Y A2 p1 VDD pmos_rvt w=46.0n l=16n nfin=2
MM2 p3 A3 VDD VDD pmos_rvt w=46.0n l=16n nfin=2
MM3 Y A4 p3 VDD pmos_rvt w=46.0n l=16n nfin=2
MM4 p2 A1 VDD VDD pmos_rvt w=46.0n l=16n nfin=2
MM5 p2 A2 VDD VDD pmos_rvt w=46.0n l=16n nfin=2
MM6 Y A3 p2 VDD pmos_rvt w=46.0n l=16n nfin=2
MM7 Y A4 p2 VDD pmos_rvt w=46.0n l=16n nfin=2
MM8 n4 A3 Y VSS nmos_rvt w=46.0n l=16n nfin=2
MM9 n4 A4 Y VSS nmos_rvt w=46.0n l=16n nfin=2
MM10 n2 A1 n4 VSS nmos_rvt w=46.0n l=16n nfin=2
MM11 n1 A2 n2 VSS nmos_rvt w=46.0n l=16n nfin=2
MM12 n3 A3 Y VSS nmos_rvt w=46.0n l=16n nfin=2
MM13 n1 A4 n3 VSS nmos_rvt w=46.0n l=16n nfin=2
MM14 VSS A1 n1 VSS nmos_rvt w=46.0n l=16n nfin=2
MM15 VSS A2 n1 VSS nmos_rvt w=46.0n l=16n nfin=2
.ENDS 4input0xFEE8_X1
