.SUBCKT 3input0x2F_X2 A1 A2 A3 VDD VSS Y
MM5 VDD na1 Y VDD pmos_rvt w=92.0n l=16n nfin=4
MM3 Y A3 n1 VDD pmos_rvt w=92.0n l=16n nfin=4
MM4 VDD na2 n1 VDD pmos_rvt w=92.0n l=16n nfin=4
MM2 Y na1 n2 VSS nmos_rvt w=92.0n l=16n nfin=4
MM1 VSS na2 n2 VSS nmos_rvt w=92.0n l=16n nfin=4
MM0 VSS A3 n2 VSS nmos_rvt w=92.0n l=16n nfin=4
MM6 na1 A1 VSS VSS nmos_rvt w=46.0n l=16n nfin=2
MM7 na1 A1 VDD VDD pmos_rvt w=46.0n l=16n nfin=2
MM8 na2 A2 VSS VSS nmos_rvt w=46.0n l=16n nfin=2
MM9 na2 A2 VDD VDD pmos_rvt w=46.0n l=16n nfin=2
.ENDS
