* selected_from: 4input0xFFE8_X1_spv20
* source_file: ck_server/moore/final.cdl
* ck_server_log: ck_server/moore/notopo_dummy0_parallel/4input0xFFE8_X1/4input0xFFE8_X1_spv20_notopo_dummy0.full.log
* dummy_for_ideal: 0
* width_cols: 13
* transistor_count: 12
* objective: 902.0
* via_count: 0
.SUBCKT 4input0xFEEA_X1 A1 A2 A3 A4 VDD VSS Y
MM0 p1 A2 VDD VDD pmos_rvt w=46.0n l=16n nfin=2
MM1 Y A3 p1 VDD pmos_rvt w=46.0n l=16n nfin=2
MM2 Y A1 VDD VDD pmos_rvt w=46.0n l=16n nfin=2
MM3 p2 A2 VDD VDD pmos_rvt w=46.0n l=16n nfin=2
MM4 p2 A3 VDD VDD pmos_rvt w=46.0n l=16n nfin=2
MM5 Y A4 p2 VDD pmos_rvt w=46.0n l=16n nfin=2
MM6 n3 A2 Y VSS nmos_rvt w=46.0n l=16n nfin=2
MM7 n2 A3 n3 VSS nmos_rvt w=46.0n l=16n nfin=2
MM8 n2 A4 Y VSS nmos_rvt w=46.0n l=16n nfin=2
MM9 n1 A1 n2 VSS nmos_rvt w=46.0n l=16n nfin=2
MM10 VSS A2 n1 VSS nmos_rvt w=46.0n l=16n nfin=2
MM11 VSS A3 n1 VSS nmos_rvt w=46.0n l=16n nfin=2
.ENDS 4input0xFEEA_X1
