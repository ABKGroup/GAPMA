.SUBCKT 2input0x2_X2 A1 A2 VDD VSS Y
MM5 na2 A2 VSS VSS nmos_rvt w=46.0n l=16n nfin=2
MM4 na2 A2 VDD VDD pmos_rvt w=46.0n l=16n nfin=2
MM3 VSS na2 Y VSS nmos_rvt w=92.0n l=16n nfin=4
MM2 VSS A1 Y VSS nmos_rvt w=92.0n l=16n nfin=4
MM1 n1 A1 Y VDD pmos_rvt w=92.0n l=16n nfin=4
MM0 VDD na2 n1 VDD pmos_rvt w=92.0n l=16n nfin=4
.ENDS
