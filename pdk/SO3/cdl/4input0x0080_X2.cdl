.SUBCKT 4input0x0080_X2 A B C D VDD VSS Y
* Canonical: 0b0000000010000000
* Function: Y = binate [small-gate search, 12 TR]
* Transistors: 12
MP0 sg4 B VDD VDD pmos_rvt W=92.0n L=16n nfin=4
MP2 sg6 A VDD VDD pmos_rvt W=92.0n L=16n nfin=4
MP3 sg6 sg4 VDD VDD pmos_rvt W=92.0n L=16n nfin=4
MP6 sg8_ps0 C VDD VDD pmos_rvt W=92.0n L=16n nfin=4
MP7 sg8_ps1 D sg8_ps0 VDD pmos_rvt W=92.0n L=16n nfin=4
MP8 Y sg6 sg8_ps1 VDD pmos_rvt W=92.0n L=16n nfin=4
MN1 sg4 B VSS VSS nmos_rvt W=92.0n L=16n nfin=4
MN4 sg6 A sg6_ns0 VSS nmos_rvt W=92.0n L=16n nfin=4
MN5 sg6_ns0 sg4 VSS VSS nmos_rvt W=92.0n L=16n nfin=4
MN9 Y C VSS VSS nmos_rvt W=92.0n L=16n nfin=4
MN10 Y D VSS VSS nmos_rvt W=92.0n L=16n nfin=4
MN11 Y sg6 VSS VSS nmos_rvt W=92.0n L=16n nfin=4
.ENDS
