.SUBCKT 3input0x6E_X1 A1 A2 A3 VDD VSS Y
MM5 VSS A1 nor3 VSS nmos_rvt w=46.0n l=16n nfin=2
MM4 VSS A2 nor3 VSS nmos_rvt w=46.0n l=16n nfin=2
MM3 VSS A3 nor3 VSS nmos_rvt w=46.0n l=16n nfin=2
MM2 n2 A1 nor3 VDD pmos_rvt w=46.0n l=16n nfin=2
MM1 n1 A3 n2 VDD pmos_rvt w=46.0n l=16n nfin=2
MM0 VDD A2 n1 VDD pmos_rvt w=46.0n l=16n nfin=2
MM6 Y nor3 VSS VSS nmos_rvt w=46.00n l=16n nfin=2
MM7 n3 A2 Y VSS nmos_rvt w=46.00n l=16n nfin=2
MM8 n3 A3 VSS VSS nmos_rvt w=46.00n l=16n nfin=2
MM9 n4 nor3 VDD VDD pmos_rvt w=46.00n l=16n nfin=2
MM10 n4 A3 Y VDD pmos_rvt w=46.00n l=16n nfin=2
MM11 n4 A2 Y VDD pmos_rvt w=46.00n l=16n nfin=2
.ENDS
