.SUBCKT 3input0x18_X1_DH_N A1 A2 A3 VDD VSS Y
MM0 VSS A1 nor2 VSS nmos_rvt w=46.0n l=16n nfin=2
MM1 VSS A2 nor2 VSS nmos_rvt w=46.0n l=16n nfin=2
MM2 n1 A2 nor2 VDD pmos_rvt w=46.0n l=16n nfin=2
MM3 VDD A1 n1 VDD pmos_rvt w=46.0n l=16n nfin=2
MM4 na3 A3 VSS VSS nmos_rvt w=46.0n l=16n nfin=2
MM5 na3 A3 VDD VDD pmos_rvt w=46.0n l=16n nfin=2
MM6 VDD A1 n2 VDD pmos_rvt w=46.00n l=16n nfin=2
MM7 VDD A2 n2 VDD pmos_rvt w=46.00n l=16n nfin=2
MM8 VDD na3 n2 VDD pmos_rvt w=46.00n l=16n nfin=2
MM9 Y nor2 n2 VDD pmos_rvt w=46.00n l=16n nfin=2
MM10 VSS nor2 Y VSS nmos_rvt w=46.00n l=16n nfin=2
MM11 n3 A2 VSS VSS nmos_rvt w=46.00n l=16n nfin=2
MM12 n4 A1 n3 VSS nmos_rvt w=46.00n l=16n nfin=2
MM13 n4 na3 Y VSS nmos_rvt w=46.00n l=16n nfin=2
.ENDS
