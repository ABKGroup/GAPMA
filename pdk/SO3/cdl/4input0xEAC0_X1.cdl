.SUBCKT 4input0xEAC0_X1 A B C D VDD VSS Y
* Canonical: 0b0000001101010111
* Function: Y = !((B+C)·(A+D)) [4 lits, SOP was 8]
* Transistors: 8
MMP1 npM0 B VDD VDD pmos_rvt W=46.0n L=16n nfin=2
MMP2 Y C npM0 VDD pmos_rvt W=46.0n L=16n nfin=2
MMP4 npM3 A VDD VDD pmos_rvt W=46.0n L=16n nfin=2
MMP5 Y D npM3 VDD pmos_rvt W=46.0n L=16n nfin=2
MMN1 Y B nsM0 VSS nmos_rvt W=46.0n L=16n nfin=2
MMN2 Y C nsM0 VSS nmos_rvt W=46.0n L=16n nfin=2
MMN3 nsM0 A VSS VSS nmos_rvt W=46.0n L=16n nfin=2
MMN4 nsM0 D VSS VSS nmos_rvt W=46.0n L=16n nfin=2
.ENDS
