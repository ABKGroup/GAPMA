.SUBCKT 3input0x3F_X1_DH_P A1 A2 A3 VDD VSS Y
MM15 n6 A2 VSS VSS nmos_rvt w=46.0n l=16n nfin=2
MM14 n5 A1 n6 VSS nmos_rvt w=46.0n l=16n nfin=2
MM13 nand3 A3 n5 VSS nmos_rvt w=46.0n l=16n nfin=2
MM12 nand3 A3 VDD VDD pmos_rvt w=46.0n l=16n nfin=2
MM11 nand3 A2 VDD VDD pmos_rvt w=46.0n l=16n nfin=2
MM10 nand3 A1 VDD VDD pmos_rvt w=46.0n l=16n nfin=2
MM0 n2 A1 VDD VDD pmos_rvt w=46.0n l=16n nfin=2
MM1 n2 A2 VDD VDD pmos_rvt w=46.0n l=16n nfin=2
MM2 n2 A3 Y VDD pmos_rvt w=46.0n l=16n nfin=2
MM3 VDD A2 n1 VDD pmos_rvt w=46.0n l=16n nfin=2
MM4 Y A1 n1 VDD pmos_rvt w=46.0n l=16n nfin=2
MM16 Y nand3 VDD VDD pmos_rvt w=46.0n l=16n nfin=2
MM5 n3 A1 VSS VSS nmos_rvt w=46.0n l=16n nfin=2
MM6 n3 A2 n4 VSS nmos_rvt w=46.0n l=16n nfin=2
MM7 n4 A3 VSS VSS nmos_rvt w=46.0n l=16n nfin=2
MM8 n4 A1 n7 VSS nmos_rvt w=46.0n l=16n nfin=2
MM9 n4 A2 n7 VSS nmos_rvt w=46.0n l=16n nfin=2
MM17 n7 nand3 Y VSS nmos_rvt w=46.0n l=16n nfin=2
.ENDS
