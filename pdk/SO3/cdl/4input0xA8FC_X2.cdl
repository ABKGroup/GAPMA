.SUBCKT 4input0xA8FC_X2 A B C D VDD VSS Y
* Canonical: 0b1010100011111100
* Function: Y = binate [small-gate search, 10 TR]
* Transistors: 10
MP0 sg4 A VDD VDD pmos_rvt W=92.0n L=16n nfin=4
MP6 sg6_p0 B VDD VDD pmos_rvt W=92.0n L=16n nfin=4
MP7 sg6_p0 C VDD VDD pmos_rvt W=92.0n L=16n nfin=4
MP8 Y D sg6_p0 VDD pmos_rvt W=92.0n L=16n nfin=4
MP9 Y sg4 sg6_p0 VDD pmos_rvt W=92.0n L=16n nfin=4
MN1 sg4 A VSS VSS nmos_rvt W=92.0n L=16n nfin=4
MN2 Y B sg6_n0 VSS nmos_rvt W=92.0n L=16n nfin=4
MN3 sg6_n0 C VSS VSS nmos_rvt W=92.0n L=16n nfin=4
MN4 Y D sg6_n1 VSS nmos_rvt W=92.0n L=16n nfin=4
MN5 sg6_n1 sg4 VSS VSS nmos_rvt W=92.0n L=16n nfin=4
.ENDS
