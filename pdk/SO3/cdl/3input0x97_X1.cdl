.SUBCKT 3input0x97_X1 A1 A2 A3 VDD VSS Y
MM0 n1 A3 planar VSS nmos_rvt w=46.0n l=16n nfin=2
MM1 n1 A2 VSS VSS nmos_rvt w=46.0n l=16n nfin=2
MM2 n2 A1 planar VSS nmos_rvt w=46.0n l=16n nfin=2
MM3 n2 A2 VSS VSS nmos_rvt w=46.0n l=16n nfin=2
MM4 n2 A3 VSS VSS nmos_rvt w=46.0n l=16n nfin=2
MM5 n3 A3 VDD VDD pmos_rvt w=46.0n l=16n nfin=2
MM6 n3 A2 VDD VDD pmos_rvt w=46.0n l=16n nfin=2
MM7 planar A1 n3 VDD pmos_rvt w=46.0n l=16n nfin=2
MM8 n4 A2 VDD VDD pmos_rvt w=46.0n l=16n nfin=2
MM9 planar A3 n4 VDD pmos_rvt w=46.0n l=16n nfin=2
MM10 n5 planar Y VSS nmos_rvt w=46.0n l=16n nfin=2
MM11 n5 A1 VSS VSS nmos_rvt w=46.0n l=16n nfin=2
MM12 n5 A2 VSS VSS nmos_rvt w=46.0n l=16n nfin=2
MM13 n5 A3 VSS VSS nmos_rvt w=46.0n l=16n nfin=2
MM14 Y planar VDD VDD pmos_rvt w=46.0n l=16n nfin=2
MM15 n6 A1 VDD VDD pmos_rvt w=46.0n l=16n nfin=2
MM16 n6 A3 n7 VDD pmos_rvt w=46.0n l=16n nfin=2
MM17 Y A2 n7 VDD pmos_rvt w=46.0n l=16n nfin=2
.ENDS
